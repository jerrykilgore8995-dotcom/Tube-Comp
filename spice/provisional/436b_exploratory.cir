Altec 436B exploratory topology - NOT VERIFIED WIRING
* This is NOT an exact tracing of the 436B drawing.
* Actual BOM values are used where known. Unknown connections are explicit guesses.
* Sidechain is rectified by 6AL5 diode proxies. Differential triodes truly conduct.
.include "models/tube_cells.lib"
.param FREQ=1000 AMP=0.15 GAIN=0.8 BIAS=-0.8
.param ATTACK_R=47000 REC_R=1000000 OUTPAD=1 SCGAIN=0.22
.param BPLUS=372 SRC_OHM=600 R6CG7_DROP=15000
.option reltol=1e-4 abstol=1e-11 method=gear
* User-specified power-supply variant: 372 V nominal before R13.
* 150uF reservoir BEFORE 10k R13; 47uF decoupling AFTER R13.
* This supply is a *candidate* pending matched idle/20-dB node measurements.
* The ideal VHT source does not model rectifier impedance or mains ripple yet.
VHT bplus 0 {BPLUS}
CRES bplus 0 150u
R13 bplus platefeed 10k
CPLATE platefeed 0 47u
VIN source 0 SIN(0 {AMP} {FREQ}) AC 1
RSOURCE source in 600
RBRIDGE in 0 15k
* Ideal differential transformer proxy; voltage ratio/loading will be re-fitted.
BGA ga 0 V={BIAS+V(cv)+GAIN*V(in)}
BGB gb 0 V={BIAS+V(cv)-GAIN*V(in)}
* Pair 6BC8 with historical 47k anode resistors and shared 34-ohm cathode.
R3 platefeed pa 47k
R4 platefeed pb 47k
XU1A pa ga k1 V6BC8
XU1B pb gb k1 V6BC8
R8 k1 0 34
* Coupling to push-pull 6CG7; R5 and R6 are historically 1M.
C2 pa g2a 22n
C3 pb g2b 22n
R5 g2a 0 1Meg
R6 g2b 0 1Meg
XU2A p2a g2a k2 V6CG7
XU2B p2b g2b k2 V6CG7
R7 k2 0 220
* Independent 6CG7 B+ supply: dedicated dropping resistor and 47uF cap.
* User requested 372V upstream, so the dropper here is a fitted stand-in.
* The original 436B parts list identifies R14 as 6.8k from a lower
* upstream voltage. DO NOT treat this 15k variant as a factory BOM.
R6CG7DROP bplus outputfeed {R6CG7_DROP}
C6CG7FILTER outputfeed 0 47u
* Output transformer 16402: idealized coupled inductor approximation.
* PRIMARY DCR must be in hundreds of ohms, NOT 18k as in the old model.
* 50H half-primaries / 12H secondary = about 10k:600 pp load ratio.
* Core loss, leakage, saturation, winding capacitance are NOT calibrated.
RWP1 outputfeed priA 200
RWP2 outputfeed priB 200
LPRI_A priA p2a 50
LPRI_B p2b priB 50
LSEC secOut 0 12
KPP LPRI_A LPRI_B 0.995
KPSA LPRI_A LSEC 0.995
KPSB LPRI_B LSEC 0.995
* Keep the output attenuator outside the power stage.
BOUT out 0 V={OUTPAD*V(secOut)}
RLOAD secOut 0 600
* Correct plate-fed 6AL5 feedback topology: source is the two 6CG7
* plates BEFORE the output attenuator, NOT a scaled sample of the 600R output.
* C5 and C6 are real 22nF blocking capacitors: DC plate voltage must
* never be injected into the control network. R10/R11 are 220k returns.
* The original 436B threshold/bias network and 6AL5 diode curves still
* need independent hardware-model calibration; +20V is the known drawing
* nominal threshold supply but the exact source is provisionally ideal.
* Two voltage-controlled AC sources set the sidechain gain before the
* physical coupling capacitors. At SCGAIN=0 they isolate the detector for
* matched-input reference measurements. UNITY is the desired hardware fit.
BSCA scaDrive 0 V={SCGAIN*V(p2a)}
BSCB scbDrive 0 V={SCGAIN*V(p2b)}
C5 scaDrive sca 22n
C6 scbDrive scb 22n
VTHRESHOLD threshold 0 20
R10 sca threshold 220k
R11 scb threshold 220k
* Sidechain drive SCGAIN is a tunable calibration multiplier; it must
* eventually be unity after verifying actual diode network loading.
* An optional differential AC coupling proxy allows level calibration
* without bypassing C5/C6 or injecting the 150V DC plates into the CV.
* Detector 6AL5 anodes collect the negative phase excursions.
DDET1 detector sca D6AL5
DDET2 detector scb D6AL5
RATT detector cv {ATTACK_R}
CREC cv 0 1u
RREC cv 0 {REC_R}
RDC detector 0 50Meg
* Simulations are not hardware-calibrated until the source-locked drawing
* and valve plate curves are verified against reference data.
.control
set wr_singlescale
set wr_vecnames
op
echo OP_BEGIN
print v(bplus) v(platefeed) v(outputfeed) v(pa) v(pb) v(k1) v(g2a) v(g2b) v(p2a) v(p2b) v(k2) v(cv) v(out)
echo OP_END
ac dec 16 20 20000
wrdata ac.txt v(out)
tran 20u 0.20 0 20u
wrdata tran.txt v(out) v(in) v(cv) v(pa) v(pb) v(p2a) v(p2b) v(k1) v(k2)
quit
.endc
.end
