UA 176T audio path through the push-pull line amplifier and T3
.include input.lib
.include amplifier.lib
.include ../models/tube_cells.lib

.param AMP=3.474135043921514 FREQ=1k SOURCE=600 LOSSDB=20 BIAS=0
.param LL=2m CS=92p HIGH=1 CATHBAL=.5 PLATEBAL=.5 METERZERO=.5 SUPPLY=108 VERNIER=0
.param B3=315 OUTVERNIER=0 OUTPUTLOAD=600 FBRES=180k TAPFRAC=1
.include front_end.inc
VBPLUS REG 0 {SUPPLY}
VLINE T3_CT 0 {B3}
* Bench source for static control-voltage sweeps.
VCV CV 0 {BIAS}

.include line_stage.inc

.options method=gear maxord=2 reltol=1e-4 abstol=1e-10 vntol=1e-5
.control
set wr_singlescale
set wr_vecnames
set numdgt=15
op
print v(v2pa) v(v2pb) v(v2ka) v(v2kb) v(v2_return) v(v2_supply)
print v(v3pa) v(v3pb) v(v3k) i(vline)
ac dec 48 10 100k
let gain = v(out_p,t3_n)/v(inp,inn)
wrdata line-ac.txt gain
quit
.endc
.end
