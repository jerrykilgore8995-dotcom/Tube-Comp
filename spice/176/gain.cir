UA 176T input and C-10476 6BC8 variable-mu stage
.include input.lib
.include ../models/tube_cells.lib

.param AMP=0.109601551 FREQ=1k SOURCE=600 LOSSDB=20 BIAS=0
.param LL=2m CS=92p HIGH=1 CATHBAL=.5 PLATEBAL=.5 METERZERO=.5 SUPPLY=108 VERNIER=0
.include front_end.inc
VBPLUS REG 0 {SUPPLY}
* Bench source for static control-voltage sweeps.
VCV CV 0 {BIAS}

* Differential approximation to the following amplifier's grid network.
* The active amplifier and its feedback are outside this bench.
R15 NEXT_P NEXT_RETURN 20k
R17 NEXT_N NEXT_RETURN 20k
CGRID_NEXT_P NEXT_P NEXT_RETURN 7p
CGRID_NEXT_N NEXT_N NEXT_RETURN 7p
RNEXT_REFERENCE NEXT_RETURN 0 1m

.options reltol=1e-7 abstol=1e-12 vntol=1e-9
.control
set wr_singlescale
set wr_vecnames
set numdgt=15
op
print v(gp) v(gn) v(ka) v(kb) v(pa) v(pb) i(VBPLUS)
ac dec 48 10 100k
let zin = v(inp,inn)/(-i(vdrive))
let winding = v(sec_p,sec_n)/v(drivep,driven)
let grids = v(gp,gn)/v(drivep,driven)
let plates = v(pb,pa)/v(drivep,driven)
let following = v(next_n,next_p)/v(drivep,driven)
wrdata gain-ac.txt zin winding grids plates following
quit
.endc
.end
