UA 176T input and C-10476 6BC8 variable-mu stage
.include input.lib
.include ../models/tube_cells.lib

.param AMP=0.109601551 FREQ=1k SOURCE=600 LOSSDB=20 BIAS=0
.param LL=2m CS=92p HIGH=1 CATHBAL=.5 PLATEBAL=.5 METERZERO=.5 SUPPLY=108 GSTOP=1k
VDRIVE DRIVEP DRIVEN DC 0 AC 1 SIN(0 {AMP} {FREQ})
RCOMMON DRIVEN 0 1G
RSOURCEP DRIVEP INP {SOURCE/2}
RSOURCEN DRIVEN INN {SOURCE/2}
XPAD INP INN TP TN UA176T_PAD LOSSDB={LOSSDB}
XT1 TP TN SEC_P SEC_N UA176_TRANSFORMER LL={LL} CS={CS}

* R2-R5 differential gain ladder. HI takes the winding ends; LO takes the taps.
R2 SEC_P TAP_P 10k
R3 TAP_P CV 6.8k
R4 CV TAP_N 6.8k
R5 TAP_N SEC_N 10k
RG_HI_P SEC_P GRID_FEED_P {ternary_fcn(HIGH,1m,1T)}
RG_LO_P TAP_P GRID_FEED_P {ternary_fcn(HIGH,1T,1m)}
RG_HI_N SEC_N GRID_FEED_N {ternary_fcn(HIGH,1m,1T)}
RG_LO_N TAP_N GRID_FEED_N {ternary_fcn(HIGH,1T,1m)}

* Provisional series grid stoppers at the 6BC8 pins.
RSTOP_P GRID_FEED_P GP {GSTOP}
RSTOP_N GRID_FEED_N GN {GSTOP}

* Normal test switch position. Limiting off grounds CV through the bench
* source at BIAS=0. Negative values drive CV externally for static sweeps.
VCV CV 0 {BIAS}
C5 CV 0 .1u

* Push-pull 6BC8 with the Sylvania law and supplied grid-current branch.
XV1A PA GP KA V6BC8
XV1B PB GN KB V6BC8
DGRIDP GP KA UA176_6BC8_GRID_DIODE
DGRIDN GN KB UA176_6BC8_GRID_DIODE
.model UA176_6BC8_GRID_DIODE D(IS=1n RS=2k CJO=1p N=1.5 TT=1n)

* R6 cathode balance pot, R10 meter-zero pot, unloaded GR meter tap.
R6A KA KRETURN {max(1m,100*CATHBAL)}
R6B KB KRETURN {max(1m,100*(1-CATHBAL))}
R7 KA KRETURN 47
R8 KB KRETURN 47
R9 KRETURN 0 330
R10A KRETURN METER {max(1m,1k*METERZERO)}
R10B METER R11TOP {max(1m,1k*(1-METERZERO))}
R11 R11TOP 0 330

* The 0B2-regulated rail is held at nominal DC for this stage bench.
VBPLUS REG 0 {SUPPLY}
C10 REG 0 .1u
R12 PA PLATE_BAL_A 4.7k
R13A PLATE_BAL_A REG {max(1m,1k*PLATEBAL)}
R13B REG PLATE_BAL_B {max(1m,1k*(1-PLATEBAL))}
R14 PLATE_BAL_B PB 4.7k

* Reverse A-19 candidate. Catalog supplies the nominal impedance ratio and
* 2.9k DCR on its 15k side. Other winding parameters are provisional.
* T2 high-Z ends go directly to the plates. The series splice is floating.
XT2 PA PB NEXT_P NEXT_N UA176_TRANSFORMER N={sqrt(15/80)} RP=4k RS=2.9k
+ LM=240 LL=.10 RC=400k CS=60p CW=15p
* Differential approximation to the following amplifier's grid network.
* The active amplifier and its feedback are outside this bench.
R15 NEXT_P NEXT_RETURN 20k
R17 NEXT_N NEXT_RETURN 20k
CGRID_NEXT_P NEXT_P NEXT_RETURN 7p
CGRID_NEXT_N NEXT_N NEXT_RETURN 7p
RNEXT_REFERENCE NEXT_RETURN 0 1m

.options reltol=1e-7 abstol=1e-12 vntol=1e-9
.control
set wr_singlescale
set wr_vecnames
set numdgt=15
op
print v(gp) v(gn) v(ka) v(kb) v(pa) v(pb) i(VBPLUS)
ac dec 48 10 100k
let zin = v(inp,inn)/(-i(vdrive))
let winding = v(sec_p,sec_n)/v(drivep,driven)
let grids = v(gp,gn)/v(drivep,driven)
let plates = v(pb,pa)/v(drivep,driven)
let following = v(next_n,next_p)/v(drivep,driven)
wrdata gain-ac.txt zin winding grids plates following
quit
.endc
.end
